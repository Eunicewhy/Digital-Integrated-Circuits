*ex2.1*
.include '7nm_TT.pm'
.temp 25
.global VDD GND

.param Vdd = 0.7v

VDD VDD GND Vdd
.include 'asap7_75t_R_24.cdl'
.include 'asap7sc7p5t_INVBUF_RVT.sp'

* Input Buffer (Smallest Inverter)
.subckt inv_buffer vin vo
    XSINV0 GND VDD vin vx INVxp33_ASAP7_75t_R
    XSINV1 GND VDD vx  vo INVxp33_ASAP7_75t_R
.ends

* PINs connected to buffer
XBUF0 A   A_buff  inv_buffer
XBUF1 B   B_buff  inv_buffer
XBUF2 Cin C_buff  inv_buffer

* Sum
XRO0 A_buff B_buff VDD GND Y_xor XOR2x2_ASAP7_75t_R
XRO1 Y_xor  C_buff VDD GND Sum   XOR2x2_ASAP7_75t_R

* Co
XMAJ0 A_buff B_buff C_buff VDD GND Co MAJx3_ASAP7_75t_R

C0 Sum GND 5f
C1 Co  GND 5f

* Input Vector
.VEC 'Ex2_1.vec'

*main
*V_A     A    0 PULSE(0 Vdd 4ns 1ps 1ps 4ns 8ns)
*V_B     B    0 PULSE(0 Vdd 2ns 1ps 1ps 2ns 4ns)
*V_Cin   Cin  0 PULSE(0 Vdd 1ns 1ps 1ps 1ns 2ns)

.tran 0.01n 15n
** Measurement
* Sum
.meas TRAN TpLH_Sum_000to001 TRIG V(Cin) VAL=0.35 RISE=1 TARG V(Sum) VAL=0.35 RISE=1
.meas TRAN TpHL_Sum_001to000 TRIG V(Cin) VAL=0.35 FALL=1 TARG V(Sum) VAL=0.35 FALL=1
.meas TRAN TpLH_Sum_000to010 TRIG V(B) VAL=0.35 RISE=1 TARG V(Sum) VAL=0.35 RISE=2
.meas TRAN TpHL_Sum_010to000 TRIG V(B) VAL=0.35 FALL=1 TARG V(Sum) VAL=0.35 FALL=2
.meas TRAN TpLH_Sum_000to100 TRIG V(A) VAL=0.35 RISE=1 TARG V(Sum) VAL=0.35 RISE=3
.meas TRAN TpHL_Sum_100to000 TRIG V(A) VAL=0.35 FALL=1 TARG V(Sum) VAL=0.35 FALL=3
.meas TRAN TpLH_Sum_000to111 TRIG V(Cin) VAL=0.35 RISE=4 TARG V(Sum) VAL=0.35 RISE=4
.meas TRAN TpHL_Sum_001to011 TRIG V(B) VAL=0.35 RISE=6 TARG V(Sum) VAL=0.35 FALL=4
.meas TRAN TpLH_Sum_011to001 TRIG V(B) VAL=0.35 FALL=6 TARG V(Sum) VAL=0.35 RISE=5
.meas TRAN TpHL_Sum_001to101 TRIG V(A) VAL=0.35 RISE=6 TARG V(Sum) VAL=0.35 FALL=5
.meas TRAN TpLH_Sun_101to001 TRIG V(A) VAL=0.35 FALL=6 TARG V(Sum) VAL=0.35 RISE=6
.meas TRAN TpHL_Sum_001to110 TRIG V(Cin) VAL=0.35 FALL=6 TARG V(Sum) VAL=0.35 FALL=6
.meas TRAN TpLH_Sum_110to001 TRIG V(Cin) VAL=0.35 RISE=7 TARG V(Sum) VAL=0.35 RISE=7
.meas TRAN TpHL_Sum_010to011 TRIG V(Cin) VAL=0.35 RISE=8 TARG V(Sum) VAL=0.35 FALL=7
.meas TRAN TpLH_Sum_011to010 TRIG V(Cin) VAL=0.35 FALL=8 TARG V(Sum) VAL=0.35 RISE=8
.meas TRAN TpHL_Sum_010to101 TRIG V(Cin) VAL=0.35 RISE=9 TARG V(Sum) VAL=0.35 FALL=8
.meas TRAN TpLH_Sum_101to010 TRIG V(Cin) VAL=0.35 FALL=9 TARG V(Sum) VAL=0.35 RISE=9
.meas TRAN TpHL_Sum_010to110 TRIG V(A) VAL=0.35 RISE=11 TARG V(Sum) VAL=0.35 FALL=9
.meas TRAN TpLH_Sum_110to010 TRIG V(A) VAL=0.35 FALL=11 TARG V(Sum) VAL=0.35 RISE=10
.meas TRAN TpHL_Sum_111to011 TRIG V(A) VAL=0.35 FALL=12 TARG V(Sum) VAL=0.35 FALL=10
.meas TRAN TpLH_Sum_011to100 TRIG V(Cin) VAL=0.35 FALL=10 TARG V(Sum) VAL=0.35 RISE=11
.meas TRAN TpHL_Sum_100to011 TRIG V(Cin) VAL=0.35 RISE=11 TARG V(Sum) VAL=0.35 FALL=11
.meas TRAN TpLH_Sum_011to111 TRIG V(A) VAL=0.35 RISE=16 TARG V(Sum) VAL=0.35 RISE=12
.meas TRAN TpHL_Sum_100to101 TRIG V(Cin) VAL=0.35 RISE=13 TARG V(Sum) VAL=0.35 FALL=12
.meas TRAN TpLH_Sum_101to100 TRIG V(Cin) VAL=0.35 FALL=13 TARG V(Sum) VAL=0.35 RISE=13
.meas TRAN TpHL_Sum_100to110 TRIG V(B) VAL=0.35 RISE=13 TARG V(Sum) VAL=0.35 FALL=13
.meas TRAN TpLH_Sum_110to100 TRIG V(B) VAL=0.35 FALL=13 TARG V(Sum) VAL=0.35 RISE=14
.meas TRAN TpHL_Sum_111to101 TRIG V(B) VAL=0.35 FALL=14 TARG V(Sum) VAL=0.35 FALL=14
.meas TRAN TpLH_Sum_101to111 TRIG V(B) VAL=0.35 RISE=16 TARG V(Sum) VAL=0.35 RISE=15
.meas TRAN TpHL_Sum_111to110 TRIG V(Cin) VAL=0.35 FALL=15 TARG V(Sum) VAL=0.35 FALL=15
.meas TRAN TpLH_Sum_110to111 TRIG V(Cin) VAL=0.35 RISE=16 TARG V(Sum) VAL=0.35 RISE=16
.meas TRAN TpHL_Sum_111to000 TRIG V(Cin) VAL=0.35 FALL=16 TARG V(Sum) VAL=0.35 FALL=16

.meas tran Sum_WorstDelay param='max(TpLH_Sum_000to001, TpHL_Sum_001to000, TpLH_Sum_000to010, TpHL_Sum_010to000, TpLH_Sum_000to100, TpHL_Sum_100to000, TpLH_Sum_000to111, TpHL_Sum_001to011, TpLH_Sum_011to001, TpHL_Sum_001to101, TpLH_Sun_101to001, TpHL_Sum_001to110, TpLH_Sum_110to001, TpHL_Sum_010to011, TpLH_Sum_011to010, TpHL_Sum_010to101, TpLH_Sum_101to010, TpHL_Sum_010to110, TpLH_Sum_110to010, TpHL_Sum_111to011, TpLH_Sum_011to100, TpHL_Sum_100to011, TpLH_Sum_011to111, TpHL_Sum_100to101, TpLH_Sum_101to100, TpHL_Sum_100to110, TpLH_Sum_110to100, TpHL_Sum_111to101, TpLH_Sum_101to111, TpHL_Sum_111to110, TpLH_Sum_110to111, TpHL_Sum_111to000)'

* Co
.meas TRAN TpLH_Co_000to011 TRIG V(Cin) VAL=0.35 RISE=2 TARG V(Co) VAL=0.35 RISE=1
.meas TRAN TpHL_Co_011to000 TRIG V(Cin) VAL=0.35 FALL=2 TARG V(Co) VAL=0.35 FALL=1
.meas TRAN TpLH_Co_000to101 TRIG V(Cin) VAL=0.35 RISE=3 TARG V(Co) VAL=0.35 RISE=2
.meas TRAN TpHL_Co_101to000 TRIG V(Cin) VAL=0.35 FALL=3 TARG V(Co) VAL=0.35 FALL=2
.meas TRAN TpLH_Co_000to110 TRIG V(B) VAL=0.35 RISE=3 TARG V(Co) VAL=0.35 RISE=3
.meas TRAN TpHL_Co_110to000 TRIG V(B) VAL=0.35 FALL=3 TARG V(Co) VAL=0.35 FALL=3
.meas TRAN TpLH_Co_000to111 TRIG V(Cin) VAL=0.35 RISE=4 TARG V(Co) VAL=0.35 RISE=4
.meas TRAN TpHL_Co_111to001 TRIG V(B) VAL=0.35 FALL=4 TARG V(Co) VAL=0.35 FALL=4
.meas TRAN TpLH_Co_001to011 TRIG V(B) VAL=0.35 RISE=6 TARG V(Co) VAL=0.35 RISE=5
.meas TRAN TpHL_Co_011to001 TRIG V(B) VAL=0.35 FALL=6 TARG V(Co) VAL=0.35 FALL=5
.meas TRAN TpLH_Co_001to101 TRIG V(A) VAL=0.35 RISE=6 TARG V(Co) VAL=0.35 RISE=6
.meas TRAN TpHL_Co_101to001 TRIG V(A) VAL=0.35 FALL=6 TARG V(Co) VAL=0.35 FALL=6
.meas TRAN TpLH_Co_001to110 TRIG V(Cin) VAL=0.35 FALL=6 TARG V(Co) VAL=0.35 RISE=7
.meas TRAN TpHL_Co_111to001 TRIG V(B) VAL=0.35 FALL=7 TARG V(Co) VAL=0.35 FALL=7
.meas TRAN TpLH_Co_001to111 TRIG V(B) VAL=0.35 RISE=8 TARG V(Co) VAL=0.35 RISE=8
.meas TRAN TpHL_Co_111to010 TRIG V(Cin) VAL=0.35 FALL=7 TARG V(Co) VAL=0.35 FALL=8
.meas TRAN TpLH_Co_010to011 TRIG V(Cin) VAL=0.35 RISE=8 TARG V(Co) VAL=0.35 RISE=9
.meas TRAN TpHL_Co_011to010 TRIG V(Cin) VAL=0.35 FALL=8 TARG V(Co) VAL=0.35 FALL=9
.meas TRAN TpLH_Co_010to101 TRIG V(Cin) VAL=0.35 RISE=9 TARG V(Co) VAL=0.35 RISE=10
.meas TRAN TpHL_Co_101to010 TRIG V(Cin) VAL=0.35 FALL=9 TARG V(Co) VAL=0.35 FALL=10
.meas TRAN TpLH_Co_010to110 TRIG V(A) VAL=0.35 RISE=11 TARG V(Co) VAL=0.35 RISE=11
.meas TRAN TpHL_Co_110to010 TRIG V(A) VAL=0.35 FALL=11 TARG V(Co) VAL=0.35 FALL=11
.meas TRAN TpLH_Co_010to111 TRIG V(Cin) VAL=0.35 RISE=10 TARG V(Co) VAL=0.35 RISE=12
.meas TRAN TpHL_Co_011to100 TRIG V(Cin) VAL=0.35 FALL=10 TARG V(Co) VAL=0.35 FALL=12
.meas TRAN TpLH_Co_100to011 TRIG V(Cin) VAL=0.35 RISE=11 TARG V(Co) VAL=0.35 RISE=13
.meas TRAN TpHL_Co_111to100 TRIG V(Cin) VAL=0.35 FALL=12 TARG V(Co) VAL=0.35 FALL=13
.meas TRAN TpLH_Co_100to101 TRIG V(Cin) VAL=0.35 RISE=13 TARG V(Co) VAL=0.35 RISE=14
.meas TRAN TpHL_Co_101to100 TRIG V(Cin) VAL=0.35 FALL=13 TARG V(Co) VAL=0.35 FALL=14
.meas TRAN TpLH_Co_100to110 TRIG V(B) VAL=0.35 RISE=13 TARG V(Co) VAL=0.35 RISE=15
.meas TRAN TpHL_Co_110to100 TRIG V(B) VAL=0.35 FALL=13 TARG V(Co) VAL=0.35 FALL=15
.meas TRAN TpLH_Co_100to111 TRIG V(Cin) VAL=0.35 RISE=14 TARG V(Co) VAL=0.35 RISE=16
.meas TRAN TpHL_Co_111to000 TRIG V(Cin) VAL=0.35 FALL=16 TARG V(Co) VAL=0.35 FALL=16

.meas TRAN Co_WorstDelay param='max(TpLH_Co_000to011, TpHL_Co_011to000, TpLH_Co_000to101, TpHL_Co_101to000, TpLH_Co_000to110, TpHL_Co_110to000, TpLH_Co_000to111, TpHL_Co_111to001, TpLH_Co_001to011, TpHL_Co_011to001, TpLH_Co_001to101, TpHL_Co_101to001, TpLH_Co_001to110, TpHL_Co_111to001, TpLH_Co_001to111, TpHL_Co_111to010, TpLH_Co_010to011, TpHL_Co_011to010, TpLH_Co_010to101, TpHL_Co_101to010, TpLH_Co_010to110, TpHL_Co_110to010, TpLH_Co_010to111, TpHL_Co_011to100, TpLH_Co_100to011, TpHL_Co_111to100, TpLH_Co_100to101, TpHL_Co_101to100, TpLH_Co_100to110, TpHL_Co_110to100, TpLH_Co_100to111, TpHL_Co_111to000)'

.meas TRAN Total_WorstDelay param='max(Sum_WorstDelay, Co_WorstDelay)'

.meas tran pwr avg power

.option post = 1
.option redefsub
.option probe
.probe v(*) i(*)
.option captab

.op

.end
